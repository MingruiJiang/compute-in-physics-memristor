include "../model/ptm45nm.ptm"
ahdl_include "../model/veriloga/opamp.va"

simulator lang=spectre
global 0

parameters ttime=5000u

R_1_1 (Row1 Col1) resistor r=1000000.0
R_1_2 (Row1 Col2) resistor r=10000.0
R_1_3 (Row1 Col3) resistor r=1000000.0
R_1_4 (Row1 Col4) resistor r=10000.0
R_1_5 (Row1 Col5) resistor r=10000.0
R_1_6 (Row1 Col6) resistor r=1000000.0
R_1_7 (Row1 Col7) resistor r=10000.0
R_1_8 (Row1 Col8) resistor r=1000000.0
R_1_9 (Row1 Col9) resistor r=1000000.0
R_1_10 (Row1 Col10) resistor r=1000000.0
R_1_11 (Row1 Col11) resistor r=1000000.0
R_1_12 (Row1 Col12) resistor r=1000000.0
R_1_13 (Row1 Col13) resistor r=1000000.0
R_1_14 (Row1 Col14) resistor r=10000.0
R_1_15 (Row1 Col15) resistor r=10000.0
R_1_16 (Row1 Col16) resistor r=10000.0
R_1_17 (Row1 Col17) resistor r=1000000.0
R_1_18 (Row1 Col18) resistor r=10000.0
R_1_19 (Row1 Col19) resistor r=1000000.0
R_1_20 (Row1 Col20) resistor r=1000000.0
R_1_21 (Row1 Col21) resistor r=10000.0
R_1_22 (Row1 Col22) resistor r=1000000.0
R_1_23 (Row1 Col23) resistor r=10000.0
R_1_24 (Row1 Col24) resistor r=1000000.0
R_1_25 (Row1 Col25) resistor r=10000.0
R_1_26 (Row1 Col26) resistor r=10000.0
R_1_27 (Row1 Col27) resistor r=1000000.0
R_1_28 (Row1 Col28) resistor r=10000.0
R_1_29 (Row1 Col29) resistor r=1000000.0
R_1_30 (Row1 Col30) resistor r=1000000.0
R_1_31 (Row1 Col31) resistor r=1000000.0
R_1_32 (Row1 Col32) resistor r=1000000.0
R_2_1 (Row2 Col1) resistor r=10000.0
R_2_2 (Row2 Col2) resistor r=1000000.0
R_2_3 (Row2 Col3) resistor r=10000.0
R_2_4 (Row2 Col4) resistor r=10000.0
R_2_5 (Row2 Col5) resistor r=10000.0
R_2_6 (Row2 Col6) resistor r=1000000.0
R_2_7 (Row2 Col7) resistor r=1000000.0
R_2_8 (Row2 Col8) resistor r=10000.0
R_2_9 (Row2 Col9) resistor r=1000000.0
R_2_10 (Row2 Col10) resistor r=10000.0
R_2_11 (Row2 Col11) resistor r=10000.0
R_2_12 (Row2 Col12) resistor r=10000.0
R_2_13 (Row2 Col13) resistor r=10000.0
R_2_14 (Row2 Col14) resistor r=10000.0
R_2_15 (Row2 Col15) resistor r=10000.0
R_2_16 (Row2 Col16) resistor r=10000.0
R_2_17 (Row2 Col17) resistor r=1000000.0
R_2_18 (Row2 Col18) resistor r=1000000.0
R_2_19 (Row2 Col19) resistor r=1000000.0
R_2_20 (Row2 Col20) resistor r=10000.0
R_2_21 (Row2 Col21) resistor r=1000000.0
R_2_22 (Row2 Col22) resistor r=10000.0
R_2_23 (Row2 Col23) resistor r=10000.0
R_2_24 (Row2 Col24) resistor r=10000.0
R_2_25 (Row2 Col25) resistor r=10000.0
R_2_26 (Row2 Col26) resistor r=10000.0
R_2_27 (Row2 Col27) resistor r=10000.0
R_2_28 (Row2 Col28) resistor r=1000000.0
R_2_29 (Row2 Col29) resistor r=1000000.0
R_2_30 (Row2 Col30) resistor r=10000.0
R_2_31 (Row2 Col31) resistor r=10000.0
R_2_32 (Row2 Col32) resistor r=10000.0
R_3_1 (Row3 Col1) resistor r=1000000.0
R_3_2 (Row3 Col2) resistor r=10000.0
R_3_3 (Row3 Col3) resistor r=1000000.0
R_3_4 (Row3 Col4) resistor r=10000.0
R_3_5 (Row3 Col5) resistor r=10000.0
R_3_6 (Row3 Col6) resistor r=10000.0
R_3_7 (Row3 Col7) resistor r=10000.0
R_3_8 (Row3 Col8) resistor r=10000.0
R_3_9 (Row3 Col9) resistor r=10000.0
R_3_10 (Row3 Col10) resistor r=1000000.0
R_3_11 (Row3 Col11) resistor r=1000000.0
R_3_12 (Row3 Col12) resistor r=1000000.0
R_3_13 (Row3 Col13) resistor r=1000000.0
R_3_14 (Row3 Col14) resistor r=10000.0
R_3_15 (Row3 Col15) resistor r=10000.0
R_3_16 (Row3 Col16) resistor r=1000000.0
R_3_17 (Row3 Col17) resistor r=10000.0
R_3_18 (Row3 Col18) resistor r=10000.0
R_3_19 (Row3 Col19) resistor r=1000000.0
R_3_20 (Row3 Col20) resistor r=1000000.0
R_3_21 (Row3 Col21) resistor r=10000.0
R_3_22 (Row3 Col22) resistor r=10000.0
R_3_23 (Row3 Col23) resistor r=10000.0
R_3_24 (Row3 Col24) resistor r=1000000.0
R_3_25 (Row3 Col25) resistor r=10000.0
R_3_26 (Row3 Col26) resistor r=10000.0
R_3_27 (Row3 Col27) resistor r=1000000.0
R_3_28 (Row3 Col28) resistor r=10000.0
R_3_29 (Row3 Col29) resistor r=10000.0
R_3_30 (Row3 Col30) resistor r=1000000.0
R_3_31 (Row3 Col31) resistor r=10000.0
R_3_32 (Row3 Col32) resistor r=1000000.0
R_4_1 (Row4 Col1) resistor r=10000.0
R_4_2 (Row4 Col2) resistor r=10000.0
R_4_3 (Row4 Col3) resistor r=10000.0
R_4_4 (Row4 Col4) resistor r=1000000.0
R_4_5 (Row4 Col5) resistor r=10000.0
R_4_6 (Row4 Col6) resistor r=1000000.0
R_4_7 (Row4 Col7) resistor r=10000.0
R_4_8 (Row4 Col8) resistor r=10000.0
R_4_9 (Row4 Col9) resistor r=1000000.0
R_4_10 (Row4 Col10) resistor r=1000000.0
R_4_11 (Row4 Col11) resistor r=10000.0
R_4_12 (Row4 Col12) resistor r=10000.0
R_4_13 (Row4 Col13) resistor r=1000000.0
R_4_14 (Row4 Col14) resistor r=10000.0
R_4_15 (Row4 Col15) resistor r=10000.0
R_4_16 (Row4 Col16) resistor r=10000.0
R_4_17 (Row4 Col17) resistor r=10000.0
R_4_18 (Row4 Col18) resistor r=1000000.0
R_4_19 (Row4 Col19) resistor r=1000000.0
R_4_20 (Row4 Col20) resistor r=10000.0
R_4_21 (Row4 Col21) resistor r=10000.0
R_4_22 (Row4 Col22) resistor r=10000.0
R_4_23 (Row4 Col23) resistor r=10000.0
R_4_24 (Row4 Col24) resistor r=1000000.0
R_4_25 (Row4 Col25) resistor r=1000000.0
R_4_26 (Row4 Col26) resistor r=10000.0
R_4_27 (Row4 Col27) resistor r=10000.0
R_4_28 (Row4 Col28) resistor r=1000000.0
R_4_29 (Row4 Col29) resistor r=1000000.0
R_4_30 (Row4 Col30) resistor r=1000000.0
R_4_31 (Row4 Col31) resistor r=1000000.0
R_4_32 (Row4 Col32) resistor r=10000.0
R_5_1 (Row5 Col1) resistor r=10000.0
R_5_2 (Row5 Col2) resistor r=10000.0
R_5_3 (Row5 Col3) resistor r=10000.0
R_5_4 (Row5 Col4) resistor r=10000.0
R_5_5 (Row5 Col5) resistor r=1000000.0
R_5_6 (Row5 Col6) resistor r=1000000.0
R_5_7 (Row5 Col7) resistor r=10000.0
R_5_8 (Row5 Col8) resistor r=1000000.0
R_5_9 (Row5 Col9) resistor r=1000000.0
R_5_10 (Row5 Col10) resistor r=10000.0
R_5_11 (Row5 Col11) resistor r=10000.0
R_5_12 (Row5 Col12) resistor r=10000.0
R_5_13 (Row5 Col13) resistor r=10000.0
R_5_14 (Row5 Col14) resistor r=10000.0
R_5_15 (Row5 Col15) resistor r=1000000.0
R_5_16 (Row5 Col16) resistor r=1000000.0
R_5_17 (Row5 Col17) resistor r=10000.0
R_5_18 (Row5 Col18) resistor r=10000.0
R_5_19 (Row5 Col19) resistor r=10000.0
R_5_20 (Row5 Col20) resistor r=10000.0
R_5_21 (Row5 Col21) resistor r=10000.0
R_5_22 (Row5 Col22) resistor r=1000000.0
R_5_23 (Row5 Col23) resistor r=10000.0
R_5_24 (Row5 Col24) resistor r=1000000.0
R_5_25 (Row5 Col25) resistor r=10000.0
R_5_26 (Row5 Col26) resistor r=10000.0
R_5_27 (Row5 Col27) resistor r=1000000.0
R_5_28 (Row5 Col28) resistor r=1000000.0
R_5_29 (Row5 Col29) resistor r=10000.0
R_5_30 (Row5 Col30) resistor r=10000.0
R_5_31 (Row5 Col31) resistor r=10000.0
R_5_32 (Row5 Col32) resistor r=1000000.0
R_6_1 (Row6 Col1) resistor r=1000000.0
R_6_2 (Row6 Col2) resistor r=1000000.0
R_6_3 (Row6 Col3) resistor r=10000.0
R_6_4 (Row6 Col4) resistor r=1000000.0
R_6_5 (Row6 Col5) resistor r=1000000.0
R_6_6 (Row6 Col6) resistor r=1000000.0
R_6_7 (Row6 Col7) resistor r=1000000.0
R_6_8 (Row6 Col8) resistor r=1000000.0
R_6_9 (Row6 Col9) resistor r=1000000.0
R_6_10 (Row6 Col10) resistor r=10000.0
R_6_11 (Row6 Col11) resistor r=1000000.0
R_6_12 (Row6 Col12) resistor r=10000.0
R_6_13 (Row6 Col13) resistor r=1000000.0
R_6_14 (Row6 Col14) resistor r=10000.0
R_6_15 (Row6 Col15) resistor r=1000000.0
R_6_16 (Row6 Col16) resistor r=10000.0
R_6_17 (Row6 Col17) resistor r=10000.0
R_6_18 (Row6 Col18) resistor r=10000.0
R_6_19 (Row6 Col19) resistor r=1000000.0
R_6_20 (Row6 Col20) resistor r=1000000.0
R_6_21 (Row6 Col21) resistor r=1000000.0
R_6_22 (Row6 Col22) resistor r=10000.0
R_6_23 (Row6 Col23) resistor r=1000000.0
R_6_24 (Row6 Col24) resistor r=10000.0
R_6_25 (Row6 Col25) resistor r=1000000.0
R_6_26 (Row6 Col26) resistor r=1000000.0
R_6_27 (Row6 Col27) resistor r=10000.0
R_6_28 (Row6 Col28) resistor r=10000.0
R_6_29 (Row6 Col29) resistor r=10000.0
R_6_30 (Row6 Col30) resistor r=10000.0
R_6_31 (Row6 Col31) resistor r=10000.0
R_6_32 (Row6 Col32) resistor r=10000.0
R_7_1 (Row7 Col1) resistor r=10000.0
R_7_2 (Row7 Col2) resistor r=1000000.0
R_7_3 (Row7 Col3) resistor r=10000.0
R_7_4 (Row7 Col4) resistor r=10000.0
R_7_5 (Row7 Col5) resistor r=10000.0
R_7_6 (Row7 Col6) resistor r=1000000.0
R_7_7 (Row7 Col7) resistor r=1000000.0
R_7_8 (Row7 Col8) resistor r=10000.0
R_7_9 (Row7 Col9) resistor r=10000.0
R_7_10 (Row7 Col10) resistor r=10000.0
R_7_11 (Row7 Col11) resistor r=10000.0
R_7_12 (Row7 Col12) resistor r=1000000.0
R_7_13 (Row7 Col13) resistor r=10000.0
R_7_14 (Row7 Col14) resistor r=10000.0
R_7_15 (Row7 Col15) resistor r=1000000.0
R_7_16 (Row7 Col16) resistor r=1000000.0
R_7_17 (Row7 Col17) resistor r=10000.0
R_7_18 (Row7 Col18) resistor r=10000.0
R_7_19 (Row7 Col19) resistor r=10000.0
R_7_20 (Row7 Col20) resistor r=1000000.0
R_7_21 (Row7 Col21) resistor r=10000.0
R_7_22 (Row7 Col22) resistor r=1000000.0
R_7_23 (Row7 Col23) resistor r=10000.0
R_7_24 (Row7 Col24) resistor r=1000000.0
R_7_25 (Row7 Col25) resistor r=1000000.0
R_7_26 (Row7 Col26) resistor r=1000000.0
R_7_27 (Row7 Col27) resistor r=10000.0
R_7_28 (Row7 Col28) resistor r=1000000.0
R_7_29 (Row7 Col29) resistor r=1000000.0
R_7_30 (Row7 Col30) resistor r=1000000.0
R_7_31 (Row7 Col31) resistor r=1000000.0
R_7_32 (Row7 Col32) resistor r=10000.0
R_8_1 (Row8 Col1) resistor r=1000000.0
R_8_2 (Row8 Col2) resistor r=10000.0
R_8_3 (Row8 Col3) resistor r=10000.0
R_8_4 (Row8 Col4) resistor r=10000.0
R_8_5 (Row8 Col5) resistor r=1000000.0
R_8_6 (Row8 Col6) resistor r=1000000.0
R_8_7 (Row8 Col7) resistor r=10000.0
R_8_8 (Row8 Col8) resistor r=1000000.0
R_8_9 (Row8 Col9) resistor r=1000000.0
R_8_10 (Row8 Col10) resistor r=1000000.0
R_8_11 (Row8 Col11) resistor r=10000.0
R_8_12 (Row8 Col12) resistor r=1000000.0
R_8_13 (Row8 Col13) resistor r=10000.0
R_8_14 (Row8 Col14) resistor r=10000.0
R_8_15 (Row8 Col15) resistor r=10000.0
R_8_16 (Row8 Col16) resistor r=1000000.0
R_8_17 (Row8 Col17) resistor r=1000000.0
R_8_18 (Row8 Col18) resistor r=1000000.0
R_8_19 (Row8 Col19) resistor r=10000.0
R_8_20 (Row8 Col20) resistor r=1000000.0
R_8_21 (Row8 Col21) resistor r=10000.0
R_8_22 (Row8 Col22) resistor r=10000.0
R_8_23 (Row8 Col23) resistor r=1000000.0
R_8_24 (Row8 Col24) resistor r=10000.0
R_8_25 (Row8 Col25) resistor r=1000000.0
R_8_26 (Row8 Col26) resistor r=1000000.0
R_8_27 (Row8 Col27) resistor r=10000.0
R_8_28 (Row8 Col28) resistor r=10000.0
R_8_29 (Row8 Col29) resistor r=10000.0
R_8_30 (Row8 Col30) resistor r=1000000.0
R_8_31 (Row8 Col31) resistor r=10000.0
R_8_32 (Row8 Col32) resistor r=10000.0
R_9_1 (Row9 Col1) resistor r=1000000.0
R_9_2 (Row9 Col2) resistor r=1000000.0
R_9_3 (Row9 Col3) resistor r=10000.0
R_9_4 (Row9 Col4) resistor r=1000000.0
R_9_5 (Row9 Col5) resistor r=1000000.0
R_9_6 (Row9 Col6) resistor r=1000000.0
R_9_7 (Row9 Col7) resistor r=10000.0
R_9_8 (Row9 Col8) resistor r=1000000.0
R_9_9 (Row9 Col9) resistor r=1000000.0
R_9_10 (Row9 Col10) resistor r=10000.0
R_9_11 (Row9 Col11) resistor r=10000.0
R_9_12 (Row9 Col12) resistor r=1000000.0
R_9_13 (Row9 Col13) resistor r=10000.0
R_9_14 (Row9 Col14) resistor r=10000.0
R_9_15 (Row9 Col15) resistor r=10000.0
R_9_16 (Row9 Col16) resistor r=10000.0
R_9_17 (Row9 Col17) resistor r=10000.0
R_9_18 (Row9 Col18) resistor r=1000000.0
R_9_19 (Row9 Col19) resistor r=1000000.0
R_9_20 (Row9 Col20) resistor r=10000.0
R_9_21 (Row9 Col21) resistor r=1000000.0
R_9_22 (Row9 Col22) resistor r=1000000.0
R_9_23 (Row9 Col23) resistor r=10000.0
R_9_24 (Row9 Col24) resistor r=1000000.0
R_9_25 (Row9 Col25) resistor r=10000.0
R_9_26 (Row9 Col26) resistor r=10000.0
R_9_27 (Row9 Col27) resistor r=1000000.0
R_9_28 (Row9 Col28) resistor r=1000000.0
R_9_29 (Row9 Col29) resistor r=10000.0
R_9_30 (Row9 Col30) resistor r=10000.0
R_9_31 (Row9 Col31) resistor r=1000000.0
R_9_32 (Row9 Col32) resistor r=10000.0
R_10_1 (Row10 Col1) resistor r=1000000.0
R_10_2 (Row10 Col2) resistor r=10000.0
R_10_3 (Row10 Col3) resistor r=1000000.0
R_10_4 (Row10 Col4) resistor r=1000000.0
R_10_5 (Row10 Col5) resistor r=10000.0
R_10_6 (Row10 Col6) resistor r=10000.0
R_10_7 (Row10 Col7) resistor r=10000.0
R_10_8 (Row10 Col8) resistor r=1000000.0
R_10_9 (Row10 Col9) resistor r=10000.0
R_10_10 (Row10 Col10) resistor r=1000000.0
R_10_11 (Row10 Col11) resistor r=10000.0
R_10_12 (Row10 Col12) resistor r=1000000.0
R_10_13 (Row10 Col13) resistor r=1000000.0
R_10_14 (Row10 Col14) resistor r=1000000.0
R_10_15 (Row10 Col15) resistor r=10000.0
R_10_16 (Row10 Col16) resistor r=10000.0
R_10_17 (Row10 Col17) resistor r=10000.0
R_10_18 (Row10 Col18) resistor r=10000.0
R_10_19 (Row10 Col19) resistor r=10000.0
R_10_20 (Row10 Col20) resistor r=1000000.0
R_10_21 (Row10 Col21) resistor r=10000.0
R_10_22 (Row10 Col22) resistor r=10000.0
R_10_23 (Row10 Col23) resistor r=1000000.0
R_10_24 (Row10 Col24) resistor r=10000.0
R_10_25 (Row10 Col25) resistor r=1000000.0
R_10_26 (Row10 Col26) resistor r=10000.0
R_10_27 (Row10 Col27) resistor r=1000000.0
R_10_28 (Row10 Col28) resistor r=1000000.0
R_10_29 (Row10 Col29) resistor r=10000.0
R_10_30 (Row10 Col30) resistor r=10000.0
R_10_31 (Row10 Col31) resistor r=10000.0
R_10_32 (Row10 Col32) resistor r=10000.0
R_11_1 (Row11 Col1) resistor r=1000000.0
R_11_2 (Row11 Col2) resistor r=10000.0
R_11_3 (Row11 Col3) resistor r=1000000.0
R_11_4 (Row11 Col4) resistor r=10000.0
R_11_5 (Row11 Col5) resistor r=10000.0
R_11_6 (Row11 Col6) resistor r=1000000.0
R_11_7 (Row11 Col7) resistor r=10000.0
R_11_8 (Row11 Col8) resistor r=10000.0
R_11_9 (Row11 Col9) resistor r=10000.0
R_11_10 (Row11 Col10) resistor r=10000.0
R_11_11 (Row11 Col11) resistor r=1000000.0
R_11_12 (Row11 Col12) resistor r=1000000.0
R_11_13 (Row11 Col13) resistor r=10000.0
R_11_14 (Row11 Col14) resistor r=10000.0
R_11_15 (Row11 Col15) resistor r=1000000.0
R_11_16 (Row11 Col16) resistor r=1000000.0
R_11_17 (Row11 Col17) resistor r=1000000.0
R_11_18 (Row11 Col18) resistor r=10000.0
R_11_19 (Row11 Col19) resistor r=10000.0
R_11_20 (Row11 Col20) resistor r=1000000.0
R_11_21 (Row11 Col21) resistor r=1000000.0
R_11_22 (Row11 Col22) resistor r=1000000.0
R_11_23 (Row11 Col23) resistor r=10000.0
R_11_24 (Row11 Col24) resistor r=1000000.0
R_11_25 (Row11 Col25) resistor r=1000000.0
R_11_26 (Row11 Col26) resistor r=10000.0
R_11_27 (Row11 Col27) resistor r=1000000.0
R_11_28 (Row11 Col28) resistor r=10000.0
R_11_29 (Row11 Col29) resistor r=10000.0
R_11_30 (Row11 Col30) resistor r=1000000.0
R_11_31 (Row11 Col31) resistor r=10000.0
R_11_32 (Row11 Col32) resistor r=1000000.0
R_12_1 (Row12 Col1) resistor r=1000000.0
R_12_2 (Row12 Col2) resistor r=10000.0
R_12_3 (Row12 Col3) resistor r=1000000.0
R_12_4 (Row12 Col4) resistor r=10000.0
R_12_5 (Row12 Col5) resistor r=10000.0
R_12_6 (Row12 Col6) resistor r=10000.0
R_12_7 (Row12 Col7) resistor r=1000000.0
R_12_8 (Row12 Col8) resistor r=1000000.0
R_12_9 (Row12 Col9) resistor r=1000000.0
R_12_10 (Row12 Col10) resistor r=1000000.0
R_12_11 (Row12 Col11) resistor r=1000000.0
R_12_12 (Row12 Col12) resistor r=1000000.0
R_12_13 (Row12 Col13) resistor r=1000000.0
R_12_14 (Row12 Col14) resistor r=10000.0
R_12_15 (Row12 Col15) resistor r=1000000.0
R_12_16 (Row12 Col16) resistor r=1000000.0
R_12_17 (Row12 Col17) resistor r=1000000.0
R_12_18 (Row12 Col18) resistor r=1000000.0
R_12_19 (Row12 Col19) resistor r=10000.0
R_12_20 (Row12 Col20) resistor r=1000000.0
R_12_21 (Row12 Col21) resistor r=1000000.0
R_12_22 (Row12 Col22) resistor r=10000.0
R_12_23 (Row12 Col23) resistor r=10000.0
R_12_24 (Row12 Col24) resistor r=10000.0
R_12_25 (Row12 Col25) resistor r=1000000.0
R_12_26 (Row12 Col26) resistor r=1000000.0
R_12_27 (Row12 Col27) resistor r=1000000.0
R_12_28 (Row12 Col28) resistor r=10000.0
R_12_29 (Row12 Col29) resistor r=1000000.0
R_12_30 (Row12 Col30) resistor r=10000.0
R_12_31 (Row12 Col31) resistor r=1000000.0
R_12_32 (Row12 Col32) resistor r=10000.0
R_13_1 (Row13 Col1) resistor r=1000000.0
R_13_2 (Row13 Col2) resistor r=10000.0
R_13_3 (Row13 Col3) resistor r=1000000.0
R_13_4 (Row13 Col4) resistor r=1000000.0
R_13_5 (Row13 Col5) resistor r=10000.0
R_13_6 (Row13 Col6) resistor r=1000000.0
R_13_7 (Row13 Col7) resistor r=10000.0
R_13_8 (Row13 Col8) resistor r=10000.0
R_13_9 (Row13 Col9) resistor r=10000.0
R_13_10 (Row13 Col10) resistor r=1000000.0
R_13_11 (Row13 Col11) resistor r=10000.0
R_13_12 (Row13 Col12) resistor r=1000000.0
R_13_13 (Row13 Col13) resistor r=1000000.0
R_13_14 (Row13 Col14) resistor r=10000.0
R_13_15 (Row13 Col15) resistor r=1000000.0
R_13_16 (Row13 Col16) resistor r=10000.0
R_13_17 (Row13 Col17) resistor r=10000.0
R_13_18 (Row13 Col18) resistor r=10000.0
R_13_19 (Row13 Col19) resistor r=10000.0
R_13_20 (Row13 Col20) resistor r=10000.0
R_13_21 (Row13 Col21) resistor r=10000.0
R_13_22 (Row13 Col22) resistor r=1000000.0
R_13_23 (Row13 Col23) resistor r=10000.0
R_13_24 (Row13 Col24) resistor r=1000000.0
R_13_25 (Row13 Col25) resistor r=10000.0
R_13_26 (Row13 Col26) resistor r=1000000.0
R_13_27 (Row13 Col27) resistor r=10000.0
R_13_28 (Row13 Col28) resistor r=10000.0
R_13_29 (Row13 Col29) resistor r=10000.0
R_13_30 (Row13 Col30) resistor r=10000.0
R_13_31 (Row13 Col31) resistor r=10000.0
R_13_32 (Row13 Col32) resistor r=1000000.0
R_14_1 (Row14 Col1) resistor r=10000.0
R_14_2 (Row14 Col2) resistor r=10000.0
R_14_3 (Row14 Col3) resistor r=10000.0
R_14_4 (Row14 Col4) resistor r=10000.0
R_14_5 (Row14 Col5) resistor r=10000.0
R_14_6 (Row14 Col6) resistor r=10000.0
R_14_7 (Row14 Col7) resistor r=10000.0
R_14_8 (Row14 Col8) resistor r=10000.0
R_14_9 (Row14 Col9) resistor r=10000.0
R_14_10 (Row14 Col10) resistor r=1000000.0
R_14_11 (Row14 Col11) resistor r=10000.0
R_14_12 (Row14 Col12) resistor r=10000.0
R_14_13 (Row14 Col13) resistor r=10000.0
R_14_14 (Row14 Col14) resistor r=1000000.0
R_14_15 (Row14 Col15) resistor r=10000.0
R_14_16 (Row14 Col16) resistor r=10000.0
R_14_17 (Row14 Col17) resistor r=1000000.0
R_14_18 (Row14 Col18) resistor r=1000000.0
R_14_19 (Row14 Col19) resistor r=1000000.0
R_14_20 (Row14 Col20) resistor r=10000.0
R_14_21 (Row14 Col21) resistor r=10000.0
R_14_22 (Row14 Col22) resistor r=1000000.0
R_14_23 (Row14 Col23) resistor r=1000000.0
R_14_24 (Row14 Col24) resistor r=10000.0
R_14_25 (Row14 Col25) resistor r=1000000.0
R_14_26 (Row14 Col26) resistor r=1000000.0
R_14_27 (Row14 Col27) resistor r=1000000.0
R_14_28 (Row14 Col28) resistor r=1000000.0
R_14_29 (Row14 Col29) resistor r=1000000.0
R_14_30 (Row14 Col30) resistor r=10000.0
R_14_31 (Row14 Col31) resistor r=1000000.0
R_14_32 (Row14 Col32) resistor r=10000.0
R_15_1 (Row15 Col1) resistor r=10000.0
R_15_2 (Row15 Col2) resistor r=10000.0
R_15_3 (Row15 Col3) resistor r=10000.0
R_15_4 (Row15 Col4) resistor r=10000.0
R_15_5 (Row15 Col5) resistor r=1000000.0
R_15_6 (Row15 Col6) resistor r=1000000.0
R_15_7 (Row15 Col7) resistor r=1000000.0
R_15_8 (Row15 Col8) resistor r=10000.0
R_15_9 (Row15 Col9) resistor r=10000.0
R_15_10 (Row15 Col10) resistor r=10000.0
R_15_11 (Row15 Col11) resistor r=1000000.0
R_15_12 (Row15 Col12) resistor r=1000000.0
R_15_13 (Row15 Col13) resistor r=1000000.0
R_15_14 (Row15 Col14) resistor r=10000.0
R_15_15 (Row15 Col15) resistor r=1000000.0
R_15_16 (Row15 Col16) resistor r=10000.0
R_15_17 (Row15 Col17) resistor r=10000.0
R_15_18 (Row15 Col18) resistor r=10000.0
R_15_19 (Row15 Col19) resistor r=10000.0
R_15_20 (Row15 Col20) resistor r=10000.0
R_15_21 (Row15 Col21) resistor r=1000000.0
R_15_22 (Row15 Col22) resistor r=10000.0
R_15_23 (Row15 Col23) resistor r=10000.0
R_15_24 (Row15 Col24) resistor r=10000.0
R_15_25 (Row15 Col25) resistor r=10000.0
R_15_26 (Row15 Col26) resistor r=1000000.0
R_15_27 (Row15 Col27) resistor r=1000000.0
R_15_28 (Row15 Col28) resistor r=1000000.0
R_15_29 (Row15 Col29) resistor r=10000.0
R_15_30 (Row15 Col30) resistor r=10000.0
R_15_31 (Row15 Col31) resistor r=10000.0
R_15_32 (Row15 Col32) resistor r=1000000.0
R_16_1 (Row16 Col1) resistor r=10000.0
R_16_2 (Row16 Col2) resistor r=10000.0
R_16_3 (Row16 Col3) resistor r=1000000.0
R_16_4 (Row16 Col4) resistor r=10000.0
R_16_5 (Row16 Col5) resistor r=1000000.0
R_16_6 (Row16 Col6) resistor r=10000.0
R_16_7 (Row16 Col7) resistor r=1000000.0
R_16_8 (Row16 Col8) resistor r=1000000.0
R_16_9 (Row16 Col9) resistor r=10000.0
R_16_10 (Row16 Col10) resistor r=10000.0
R_16_11 (Row16 Col11) resistor r=1000000.0
R_16_12 (Row16 Col12) resistor r=1000000.0
R_16_13 (Row16 Col13) resistor r=10000.0
R_16_14 (Row16 Col14) resistor r=10000.0
R_16_15 (Row16 Col15) resistor r=10000.0
R_16_16 (Row16 Col16) resistor r=1000000.0
R_16_17 (Row16 Col17) resistor r=10000.0
R_16_18 (Row16 Col18) resistor r=10000.0
R_16_19 (Row16 Col19) resistor r=1000000.0
R_16_20 (Row16 Col20) resistor r=1000000.0
R_16_21 (Row16 Col21) resistor r=10000.0
R_16_22 (Row16 Col22) resistor r=1000000.0
R_16_23 (Row16 Col23) resistor r=10000.0
R_16_24 (Row16 Col24) resistor r=1000000.0
R_16_25 (Row16 Col25) resistor r=1000000.0
R_16_26 (Row16 Col26) resistor r=10000.0
R_16_27 (Row16 Col27) resistor r=1000000.0
R_16_28 (Row16 Col28) resistor r=1000000.0
R_16_29 (Row16 Col29) resistor r=10000.0
R_16_30 (Row16 Col30) resistor r=1000000.0
R_16_31 (Row16 Col31) resistor r=1000000.0
R_16_32 (Row16 Col32) resistor r=1000000.0
R_17_1 (Row17 Col1) resistor r=1000000.0
R_17_2 (Row17 Col2) resistor r=1000000.0
R_17_3 (Row17 Col3) resistor r=10000.0
R_17_4 (Row17 Col4) resistor r=10000.0
R_17_5 (Row17 Col5) resistor r=10000.0
R_17_6 (Row17 Col6) resistor r=10000.0
R_17_7 (Row17 Col7) resistor r=10000.0
R_17_8 (Row17 Col8) resistor r=1000000.0
R_17_9 (Row17 Col9) resistor r=10000.0
R_17_10 (Row17 Col10) resistor r=10000.0
R_17_11 (Row17 Col11) resistor r=1000000.0
R_17_12 (Row17 Col12) resistor r=1000000.0
R_17_13 (Row17 Col13) resistor r=10000.0
R_17_14 (Row17 Col14) resistor r=1000000.0
R_17_15 (Row17 Col15) resistor r=10000.0
R_17_16 (Row17 Col16) resistor r=10000.0
R_17_17 (Row17 Col17) resistor r=1000000.0
R_17_18 (Row17 Col18) resistor r=10000.0
R_17_19 (Row17 Col19) resistor r=10000.0
R_17_20 (Row17 Col20) resistor r=1000000.0
R_17_21 (Row17 Col21) resistor r=10000.0
R_17_22 (Row17 Col22) resistor r=1000000.0
R_17_23 (Row17 Col23) resistor r=1000000.0
R_17_24 (Row17 Col24) resistor r=10000.0
R_17_25 (Row17 Col25) resistor r=1000000.0
R_17_26 (Row17 Col26) resistor r=10000.0
R_17_27 (Row17 Col27) resistor r=1000000.0
R_17_28 (Row17 Col28) resistor r=10000.0
R_17_29 (Row17 Col29) resistor r=10000.0
R_17_30 (Row17 Col30) resistor r=1000000.0
R_17_31 (Row17 Col31) resistor r=10000.0
R_17_32 (Row17 Col32) resistor r=1000000.0
R_18_1 (Row18 Col1) resistor r=10000.0
R_18_2 (Row18 Col2) resistor r=1000000.0
R_18_3 (Row18 Col3) resistor r=10000.0
R_18_4 (Row18 Col4) resistor r=1000000.0
R_18_5 (Row18 Col5) resistor r=10000.0
R_18_6 (Row18 Col6) resistor r=10000.0
R_18_7 (Row18 Col7) resistor r=10000.0
R_18_8 (Row18 Col8) resistor r=1000000.0
R_18_9 (Row18 Col9) resistor r=1000000.0
R_18_10 (Row18 Col10) resistor r=10000.0
R_18_11 (Row18 Col11) resistor r=10000.0
R_18_12 (Row18 Col12) resistor r=1000000.0
R_18_13 (Row18 Col13) resistor r=10000.0
R_18_14 (Row18 Col14) resistor r=1000000.0
R_18_15 (Row18 Col15) resistor r=10000.0
R_18_16 (Row18 Col16) resistor r=10000.0
R_18_17 (Row18 Col17) resistor r=10000.0
R_18_18 (Row18 Col18) resistor r=1000000.0
R_18_19 (Row18 Col19) resistor r=1000000.0
R_18_20 (Row18 Col20) resistor r=10000.0
R_18_21 (Row18 Col21) resistor r=1000000.0
R_18_22 (Row18 Col22) resistor r=10000.0
R_18_23 (Row18 Col23) resistor r=1000000.0
R_18_24 (Row18 Col24) resistor r=1000000.0
R_18_25 (Row18 Col25) resistor r=10000.0
R_18_26 (Row18 Col26) resistor r=10000.0
R_18_27 (Row18 Col27) resistor r=1000000.0
R_18_28 (Row18 Col28) resistor r=10000.0
R_18_29 (Row18 Col29) resistor r=10000.0
R_18_30 (Row18 Col30) resistor r=10000.0
R_18_31 (Row18 Col31) resistor r=10000.0
R_18_32 (Row18 Col32) resistor r=10000.0
R_19_1 (Row19 Col1) resistor r=1000000.0
R_19_2 (Row19 Col2) resistor r=1000000.0
R_19_3 (Row19 Col3) resistor r=1000000.0
R_19_4 (Row19 Col4) resistor r=1000000.0
R_19_5 (Row19 Col5) resistor r=10000.0
R_19_6 (Row19 Col6) resistor r=1000000.0
R_19_7 (Row19 Col7) resistor r=10000.0
R_19_8 (Row19 Col8) resistor r=10000.0
R_19_9 (Row19 Col9) resistor r=1000000.0
R_19_10 (Row19 Col10) resistor r=10000.0
R_19_11 (Row19 Col11) resistor r=10000.0
R_19_12 (Row19 Col12) resistor r=10000.0
R_19_13 (Row19 Col13) resistor r=10000.0
R_19_14 (Row19 Col14) resistor r=1000000.0
R_19_15 (Row19 Col15) resistor r=10000.0
R_19_16 (Row19 Col16) resistor r=1000000.0
R_19_17 (Row19 Col17) resistor r=10000.0
R_19_18 (Row19 Col18) resistor r=1000000.0
R_19_19 (Row19 Col19) resistor r=1000000.0
R_19_20 (Row19 Col20) resistor r=1000000.0
R_19_21 (Row19 Col21) resistor r=1000000.0
R_19_22 (Row19 Col22) resistor r=10000.0
R_19_23 (Row19 Col23) resistor r=10000.0
R_19_24 (Row19 Col24) resistor r=1000000.0
R_19_25 (Row19 Col25) resistor r=1000000.0
R_19_26 (Row19 Col26) resistor r=1000000.0
R_19_27 (Row19 Col27) resistor r=10000.0
R_19_28 (Row19 Col28) resistor r=10000.0
R_19_29 (Row19 Col29) resistor r=10000.0
R_19_30 (Row19 Col30) resistor r=1000000.0
R_19_31 (Row19 Col31) resistor r=1000000.0
R_19_32 (Row19 Col32) resistor r=10000.0
R_20_1 (Row20 Col1) resistor r=1000000.0
R_20_2 (Row20 Col2) resistor r=10000.0
R_20_3 (Row20 Col3) resistor r=1000000.0
R_20_4 (Row20 Col4) resistor r=10000.0
R_20_5 (Row20 Col5) resistor r=10000.0
R_20_6 (Row20 Col6) resistor r=1000000.0
R_20_7 (Row20 Col7) resistor r=1000000.0
R_20_8 (Row20 Col8) resistor r=1000000.0
R_20_9 (Row20 Col9) resistor r=10000.0
R_20_10 (Row20 Col10) resistor r=1000000.0
R_20_11 (Row20 Col11) resistor r=1000000.0
R_20_12 (Row20 Col12) resistor r=1000000.0
R_20_13 (Row20 Col13) resistor r=10000.0
R_20_14 (Row20 Col14) resistor r=10000.0
R_20_15 (Row20 Col15) resistor r=10000.0
R_20_16 (Row20 Col16) resistor r=1000000.0
R_20_17 (Row20 Col17) resistor r=1000000.0
R_20_18 (Row20 Col18) resistor r=10000.0
R_20_19 (Row20 Col19) resistor r=1000000.0
R_20_20 (Row20 Col20) resistor r=1000000.0
R_20_21 (Row20 Col21) resistor r=10000.0
R_20_22 (Row20 Col22) resistor r=1000000.0
R_20_23 (Row20 Col23) resistor r=10000.0
R_20_24 (Row20 Col24) resistor r=1000000.0
R_20_25 (Row20 Col25) resistor r=1000000.0
R_20_26 (Row20 Col26) resistor r=10000.0
R_20_27 (Row20 Col27) resistor r=1000000.0
R_20_28 (Row20 Col28) resistor r=1000000.0
R_20_29 (Row20 Col29) resistor r=10000.0
R_20_30 (Row20 Col30) resistor r=1000000.0
R_20_31 (Row20 Col31) resistor r=10000.0
R_20_32 (Row20 Col32) resistor r=10000.0
R_21_1 (Row21 Col1) resistor r=10000.0
R_21_2 (Row21 Col2) resistor r=1000000.0
R_21_3 (Row21 Col3) resistor r=10000.0
R_21_4 (Row21 Col4) resistor r=10000.0
R_21_5 (Row21 Col5) resistor r=10000.0
R_21_6 (Row21 Col6) resistor r=1000000.0
R_21_7 (Row21 Col7) resistor r=10000.0
R_21_8 (Row21 Col8) resistor r=10000.0
R_21_9 (Row21 Col9) resistor r=1000000.0
R_21_10 (Row21 Col10) resistor r=10000.0
R_21_11 (Row21 Col11) resistor r=1000000.0
R_21_12 (Row21 Col12) resistor r=1000000.0
R_21_13 (Row21 Col13) resistor r=10000.0
R_21_14 (Row21 Col14) resistor r=10000.0
R_21_15 (Row21 Col15) resistor r=1000000.0
R_21_16 (Row21 Col16) resistor r=10000.0
R_21_17 (Row21 Col17) resistor r=10000.0
R_21_18 (Row21 Col18) resistor r=1000000.0
R_21_19 (Row21 Col19) resistor r=1000000.0
R_21_20 (Row21 Col20) resistor r=10000.0
R_21_21 (Row21 Col21) resistor r=1000000.0
R_21_22 (Row21 Col22) resistor r=10000.0
R_21_23 (Row21 Col23) resistor r=10000.0
R_21_24 (Row21 Col24) resistor r=1000000.0
R_21_25 (Row21 Col25) resistor r=1000000.0
R_21_26 (Row21 Col26) resistor r=10000.0
R_21_27 (Row21 Col27) resistor r=1000000.0
R_21_28 (Row21 Col28) resistor r=10000.0
R_21_29 (Row21 Col29) resistor r=1000000.0
R_21_30 (Row21 Col30) resistor r=1000000.0
R_21_31 (Row21 Col31) resistor r=10000.0
R_21_32 (Row21 Col32) resistor r=1000000.0
R_22_1 (Row22 Col1) resistor r=1000000.0
R_22_2 (Row22 Col2) resistor r=10000.0
R_22_3 (Row22 Col3) resistor r=10000.0
R_22_4 (Row22 Col4) resistor r=10000.0
R_22_5 (Row22 Col5) resistor r=1000000.0
R_22_6 (Row22 Col6) resistor r=10000.0
R_22_7 (Row22 Col7) resistor r=1000000.0
R_22_8 (Row22 Col8) resistor r=10000.0
R_22_9 (Row22 Col9) resistor r=1000000.0
R_22_10 (Row22 Col10) resistor r=10000.0
R_22_11 (Row22 Col11) resistor r=1000000.0
R_22_12 (Row22 Col12) resistor r=10000.0
R_22_13 (Row22 Col13) resistor r=1000000.0
R_22_14 (Row22 Col14) resistor r=1000000.0
R_22_15 (Row22 Col15) resistor r=10000.0
R_22_16 (Row22 Col16) resistor r=1000000.0
R_22_17 (Row22 Col17) resistor r=1000000.0
R_22_18 (Row22 Col18) resistor r=10000.0
R_22_19 (Row22 Col19) resistor r=10000.0
R_22_20 (Row22 Col20) resistor r=1000000.0
R_22_21 (Row22 Col21) resistor r=10000.0
R_22_22 (Row22 Col22) resistor r=1000000.0
R_22_23 (Row22 Col23) resistor r=1000000.0
R_22_24 (Row22 Col24) resistor r=10000.0
R_22_25 (Row22 Col25) resistor r=10000.0
R_22_26 (Row22 Col26) resistor r=1000000.0
R_22_27 (Row22 Col27) resistor r=10000.0
R_22_28 (Row22 Col28) resistor r=10000.0
R_22_29 (Row22 Col29) resistor r=1000000.0
R_22_30 (Row22 Col30) resistor r=1000000.0
R_22_31 (Row22 Col31) resistor r=1000000.0
R_22_32 (Row22 Col32) resistor r=1000000.0
R_23_1 (Row23 Col1) resistor r=10000.0
R_23_2 (Row23 Col2) resistor r=10000.0
R_23_3 (Row23 Col3) resistor r=10000.0
R_23_4 (Row23 Col4) resistor r=10000.0
R_23_5 (Row23 Col5) resistor r=10000.0
R_23_6 (Row23 Col6) resistor r=1000000.0
R_23_7 (Row23 Col7) resistor r=10000.0
R_23_8 (Row23 Col8) resistor r=1000000.0
R_23_9 (Row23 Col9) resistor r=10000.0
R_23_10 (Row23 Col10) resistor r=1000000.0
R_23_11 (Row23 Col11) resistor r=10000.0
R_23_12 (Row23 Col12) resistor r=10000.0
R_23_13 (Row23 Col13) resistor r=10000.0
R_23_14 (Row23 Col14) resistor r=1000000.0
R_23_15 (Row23 Col15) resistor r=10000.0
R_23_16 (Row23 Col16) resistor r=10000.0
R_23_17 (Row23 Col17) resistor r=1000000.0
R_23_18 (Row23 Col18) resistor r=1000000.0
R_23_19 (Row23 Col19) resistor r=10000.0
R_23_20 (Row23 Col20) resistor r=10000.0
R_23_21 (Row23 Col21) resistor r=10000.0
R_23_22 (Row23 Col22) resistor r=1000000.0
R_23_23 (Row23 Col23) resistor r=1000000.0
R_23_24 (Row23 Col24) resistor r=10000.0
R_23_25 (Row23 Col25) resistor r=1000000.0
R_23_26 (Row23 Col26) resistor r=10000.0
R_23_27 (Row23 Col27) resistor r=10000.0
R_23_28 (Row23 Col28) resistor r=1000000.0
R_23_29 (Row23 Col29) resistor r=1000000.0
R_23_30 (Row23 Col30) resistor r=10000.0
R_23_31 (Row23 Col31) resistor r=1000000.0
R_23_32 (Row23 Col32) resistor r=1000000.0
R_24_1 (Row24 Col1) resistor r=1000000.0
R_24_2 (Row24 Col2) resistor r=10000.0
R_24_3 (Row24 Col3) resistor r=1000000.0
R_24_4 (Row24 Col4) resistor r=1000000.0
R_24_5 (Row24 Col5) resistor r=1000000.0
R_24_6 (Row24 Col6) resistor r=10000.0
R_24_7 (Row24 Col7) resistor r=1000000.0
R_24_8 (Row24 Col8) resistor r=10000.0
R_24_9 (Row24 Col9) resistor r=1000000.0
R_24_10 (Row24 Col10) resistor r=10000.0
R_24_11 (Row24 Col11) resistor r=1000000.0
R_24_12 (Row24 Col12) resistor r=10000.0
R_24_13 (Row24 Col13) resistor r=1000000.0
R_24_14 (Row24 Col14) resistor r=10000.0
R_24_15 (Row24 Col15) resistor r=10000.0
R_24_16 (Row24 Col16) resistor r=1000000.0
R_24_17 (Row24 Col17) resistor r=10000.0
R_24_18 (Row24 Col18) resistor r=1000000.0
R_24_19 (Row24 Col19) resistor r=1000000.0
R_24_20 (Row24 Col20) resistor r=1000000.0
R_24_21 (Row24 Col21) resistor r=1000000.0
R_24_22 (Row24 Col22) resistor r=10000.0
R_24_23 (Row24 Col23) resistor r=10000.0
R_24_24 (Row24 Col24) resistor r=1000000.0
R_24_25 (Row24 Col25) resistor r=10000.0
R_24_26 (Row24 Col26) resistor r=10000.0
R_24_27 (Row24 Col27) resistor r=10000.0
R_24_28 (Row24 Col28) resistor r=10000.0
R_24_29 (Row24 Col29) resistor r=10000.0
R_24_30 (Row24 Col30) resistor r=10000.0
R_24_31 (Row24 Col31) resistor r=10000.0
R_24_32 (Row24 Col32) resistor r=10000.0
R_25_1 (Row25 Col1) resistor r=10000.0
R_25_2 (Row25 Col2) resistor r=10000.0
R_25_3 (Row25 Col3) resistor r=10000.0
R_25_4 (Row25 Col4) resistor r=1000000.0
R_25_5 (Row25 Col5) resistor r=10000.0
R_25_6 (Row25 Col6) resistor r=1000000.0
R_25_7 (Row25 Col7) resistor r=1000000.0
R_25_8 (Row25 Col8) resistor r=1000000.0
R_25_9 (Row25 Col9) resistor r=10000.0
R_25_10 (Row25 Col10) resistor r=1000000.0
R_25_11 (Row25 Col11) resistor r=1000000.0
R_25_12 (Row25 Col12) resistor r=1000000.0
R_25_13 (Row25 Col13) resistor r=10000.0
R_25_14 (Row25 Col14) resistor r=1000000.0
R_25_15 (Row25 Col15) resistor r=10000.0
R_25_16 (Row25 Col16) resistor r=1000000.0
R_25_17 (Row25 Col17) resistor r=1000000.0
R_25_18 (Row25 Col18) resistor r=10000.0
R_25_19 (Row25 Col19) resistor r=1000000.0
R_25_20 (Row25 Col20) resistor r=1000000.0
R_25_21 (Row25 Col21) resistor r=1000000.0
R_25_22 (Row25 Col22) resistor r=10000.0
R_25_23 (Row25 Col23) resistor r=1000000.0
R_25_24 (Row25 Col24) resistor r=10000.0
R_25_25 (Row25 Col25) resistor r=1000000.0
R_25_26 (Row25 Col26) resistor r=10000.0
R_25_27 (Row25 Col27) resistor r=1000000.0
R_25_28 (Row25 Col28) resistor r=10000.0
R_25_29 (Row25 Col29) resistor r=1000000.0
R_25_30 (Row25 Col30) resistor r=10000.0
R_25_31 (Row25 Col31) resistor r=10000.0
R_25_32 (Row25 Col32) resistor r=10000.0
R_26_1 (Row26 Col1) resistor r=10000.0
R_26_2 (Row26 Col2) resistor r=10000.0
R_26_3 (Row26 Col3) resistor r=10000.0
R_26_4 (Row26 Col4) resistor r=10000.0
R_26_5 (Row26 Col5) resistor r=10000.0
R_26_6 (Row26 Col6) resistor r=1000000.0
R_26_7 (Row26 Col7) resistor r=1000000.0
R_26_8 (Row26 Col8) resistor r=1000000.0
R_26_9 (Row26 Col9) resistor r=10000.0
R_26_10 (Row26 Col10) resistor r=10000.0
R_26_11 (Row26 Col11) resistor r=10000.0
R_26_12 (Row26 Col12) resistor r=1000000.0
R_26_13 (Row26 Col13) resistor r=1000000.0
R_26_14 (Row26 Col14) resistor r=1000000.0
R_26_15 (Row26 Col15) resistor r=1000000.0
R_26_16 (Row26 Col16) resistor r=10000.0
R_26_17 (Row26 Col17) resistor r=10000.0
R_26_18 (Row26 Col18) resistor r=10000.0
R_26_19 (Row26 Col19) resistor r=1000000.0
R_26_20 (Row26 Col20) resistor r=10000.0
R_26_21 (Row26 Col21) resistor r=10000.0
R_26_22 (Row26 Col22) resistor r=1000000.0
R_26_23 (Row26 Col23) resistor r=10000.0
R_26_24 (Row26 Col24) resistor r=10000.0
R_26_25 (Row26 Col25) resistor r=10000.0
R_26_26 (Row26 Col26) resistor r=1000000.0
R_26_27 (Row26 Col27) resistor r=1000000.0
R_26_28 (Row26 Col28) resistor r=10000.0
R_26_29 (Row26 Col29) resistor r=10000.0
R_26_30 (Row26 Col30) resistor r=1000000.0
R_26_31 (Row26 Col31) resistor r=1000000.0
R_26_32 (Row26 Col32) resistor r=1000000.0
R_27_1 (Row27 Col1) resistor r=1000000.0
R_27_2 (Row27 Col2) resistor r=10000.0
R_27_3 (Row27 Col3) resistor r=1000000.0
R_27_4 (Row27 Col4) resistor r=10000.0
R_27_5 (Row27 Col5) resistor r=1000000.0
R_27_6 (Row27 Col6) resistor r=10000.0
R_27_7 (Row27 Col7) resistor r=10000.0
R_27_8 (Row27 Col8) resistor r=10000.0
R_27_9 (Row27 Col9) resistor r=1000000.0
R_27_10 (Row27 Col10) resistor r=1000000.0
R_27_11 (Row27 Col11) resistor r=1000000.0
R_27_12 (Row27 Col12) resistor r=1000000.0
R_27_13 (Row27 Col13) resistor r=10000.0
R_27_14 (Row27 Col14) resistor r=1000000.0
R_27_15 (Row27 Col15) resistor r=1000000.0
R_27_16 (Row27 Col16) resistor r=1000000.0
R_27_17 (Row27 Col17) resistor r=1000000.0
R_27_18 (Row27 Col18) resistor r=1000000.0
R_27_19 (Row27 Col19) resistor r=10000.0
R_27_20 (Row27 Col20) resistor r=1000000.0
R_27_21 (Row27 Col21) resistor r=1000000.0
R_27_22 (Row27 Col22) resistor r=10000.0
R_27_23 (Row27 Col23) resistor r=10000.0
R_27_24 (Row27 Col24) resistor r=10000.0
R_27_25 (Row27 Col25) resistor r=1000000.0
R_27_26 (Row27 Col26) resistor r=1000000.0
R_27_27 (Row27 Col27) resistor r=1000000.0
R_27_28 (Row27 Col28) resistor r=1000000.0
R_27_29 (Row27 Col29) resistor r=1000000.0
R_27_30 (Row27 Col30) resistor r=1000000.0
R_27_31 (Row27 Col31) resistor r=10000.0
R_27_32 (Row27 Col32) resistor r=1000000.0
R_28_1 (Row28 Col1) resistor r=10000.0
R_28_2 (Row28 Col2) resistor r=1000000.0
R_28_3 (Row28 Col3) resistor r=10000.0
R_28_4 (Row28 Col4) resistor r=1000000.0
R_28_5 (Row28 Col5) resistor r=1000000.0
R_28_6 (Row28 Col6) resistor r=10000.0
R_28_7 (Row28 Col7) resistor r=1000000.0
R_28_8 (Row28 Col8) resistor r=10000.0
R_28_9 (Row28 Col9) resistor r=1000000.0
R_28_10 (Row28 Col10) resistor r=1000000.0
R_28_11 (Row28 Col11) resistor r=10000.0
R_28_12 (Row28 Col12) resistor r=10000.0
R_28_13 (Row28 Col13) resistor r=10000.0
R_28_14 (Row28 Col14) resistor r=1000000.0
R_28_15 (Row28 Col15) resistor r=1000000.0
R_28_16 (Row28 Col16) resistor r=1000000.0
R_28_17 (Row28 Col17) resistor r=10000.0
R_28_18 (Row28 Col18) resistor r=10000.0
R_28_19 (Row28 Col19) resistor r=10000.0
R_28_20 (Row28 Col20) resistor r=1000000.0
R_28_21 (Row28 Col21) resistor r=10000.0
R_28_22 (Row28 Col22) resistor r=10000.0
R_28_23 (Row28 Col23) resistor r=1000000.0
R_28_24 (Row28 Col24) resistor r=10000.0
R_28_25 (Row28 Col25) resistor r=10000.0
R_28_26 (Row28 Col26) resistor r=10000.0
R_28_27 (Row28 Col27) resistor r=1000000.0
R_28_28 (Row28 Col28) resistor r=1000000.0
R_28_29 (Row28 Col29) resistor r=1000000.0
R_28_30 (Row28 Col30) resistor r=10000.0
R_28_31 (Row28 Col31) resistor r=1000000.0
R_28_32 (Row28 Col32) resistor r=10000.0
R_29_1 (Row29 Col1) resistor r=1000000.0
R_29_2 (Row29 Col2) resistor r=1000000.0
R_29_3 (Row29 Col3) resistor r=10000.0
R_29_4 (Row29 Col4) resistor r=1000000.0
R_29_5 (Row29 Col5) resistor r=10000.0
R_29_6 (Row29 Col6) resistor r=10000.0
R_29_7 (Row29 Col7) resistor r=1000000.0
R_29_8 (Row29 Col8) resistor r=10000.0
R_29_9 (Row29 Col9) resistor r=10000.0
R_29_10 (Row29 Col10) resistor r=10000.0
R_29_11 (Row29 Col11) resistor r=10000.0
R_29_12 (Row29 Col12) resistor r=1000000.0
R_29_13 (Row29 Col13) resistor r=10000.0
R_29_14 (Row29 Col14) resistor r=1000000.0
R_29_15 (Row29 Col15) resistor r=10000.0
R_29_16 (Row29 Col16) resistor r=10000.0
R_29_17 (Row29 Col17) resistor r=10000.0
R_29_18 (Row29 Col18) resistor r=10000.0
R_29_19 (Row29 Col19) resistor r=10000.0
R_29_20 (Row29 Col20) resistor r=10000.0
R_29_21 (Row29 Col21) resistor r=1000000.0
R_29_22 (Row29 Col22) resistor r=1000000.0
R_29_23 (Row29 Col23) resistor r=1000000.0
R_29_24 (Row29 Col24) resistor r=10000.0
R_29_25 (Row29 Col25) resistor r=1000000.0
R_29_26 (Row29 Col26) resistor r=10000.0
R_29_27 (Row29 Col27) resistor r=1000000.0
R_29_28 (Row29 Col28) resistor r=1000000.0
R_29_29 (Row29 Col29) resistor r=1000000.0
R_29_30 (Row29 Col30) resistor r=1000000.0
R_29_31 (Row29 Col31) resistor r=1000000.0
R_29_32 (Row29 Col32) resistor r=10000.0
R_30_1 (Row30 Col1) resistor r=1000000.0
R_30_2 (Row30 Col2) resistor r=10000.0
R_30_3 (Row30 Col3) resistor r=1000000.0
R_30_4 (Row30 Col4) resistor r=1000000.0
R_30_5 (Row30 Col5) resistor r=10000.0
R_30_6 (Row30 Col6) resistor r=10000.0
R_30_7 (Row30 Col7) resistor r=1000000.0
R_30_8 (Row30 Col8) resistor r=1000000.0
R_30_9 (Row30 Col9) resistor r=10000.0
R_30_10 (Row30 Col10) resistor r=10000.0
R_30_11 (Row30 Col11) resistor r=1000000.0
R_30_12 (Row30 Col12) resistor r=10000.0
R_30_13 (Row30 Col13) resistor r=10000.0
R_30_14 (Row30 Col14) resistor r=10000.0
R_30_15 (Row30 Col15) resistor r=10000.0
R_30_16 (Row30 Col16) resistor r=1000000.0
R_30_17 (Row30 Col17) resistor r=1000000.0
R_30_18 (Row30 Col18) resistor r=10000.0
R_30_19 (Row30 Col19) resistor r=1000000.0
R_30_20 (Row30 Col20) resistor r=1000000.0
R_30_21 (Row30 Col21) resistor r=1000000.0
R_30_22 (Row30 Col22) resistor r=1000000.0
R_30_23 (Row30 Col23) resistor r=10000.0
R_30_24 (Row30 Col24) resistor r=10000.0
R_30_25 (Row30 Col25) resistor r=10000.0
R_30_26 (Row30 Col26) resistor r=1000000.0
R_30_27 (Row30 Col27) resistor r=1000000.0
R_30_28 (Row30 Col28) resistor r=10000.0
R_30_29 (Row30 Col29) resistor r=1000000.0
R_30_30 (Row30 Col30) resistor r=1000000.0
R_30_31 (Row30 Col31) resistor r=1000000.0
R_30_32 (Row30 Col32) resistor r=10000.0
R_31_1 (Row31 Col1) resistor r=1000000.0
R_31_2 (Row31 Col2) resistor r=10000.0
R_31_3 (Row31 Col3) resistor r=10000.0
R_31_4 (Row31 Col4) resistor r=1000000.0
R_31_5 (Row31 Col5) resistor r=10000.0
R_31_6 (Row31 Col6) resistor r=10000.0
R_31_7 (Row31 Col7) resistor r=1000000.0
R_31_8 (Row31 Col8) resistor r=10000.0
R_31_9 (Row31 Col9) resistor r=1000000.0
R_31_10 (Row31 Col10) resistor r=10000.0
R_31_11 (Row31 Col11) resistor r=10000.0
R_31_12 (Row31 Col12) resistor r=1000000.0
R_31_13 (Row31 Col13) resistor r=10000.0
R_31_14 (Row31 Col14) resistor r=1000000.0
R_31_15 (Row31 Col15) resistor r=10000.0
R_31_16 (Row31 Col16) resistor r=1000000.0
R_31_17 (Row31 Col17) resistor r=10000.0
R_31_18 (Row31 Col18) resistor r=10000.0
R_31_19 (Row31 Col19) resistor r=1000000.0
R_31_20 (Row31 Col20) resistor r=10000.0
R_31_21 (Row31 Col21) resistor r=10000.0
R_31_22 (Row31 Col22) resistor r=1000000.0
R_31_23 (Row31 Col23) resistor r=1000000.0
R_31_24 (Row31 Col24) resistor r=10000.0
R_31_25 (Row31 Col25) resistor r=10000.0
R_31_26 (Row31 Col26) resistor r=1000000.0
R_31_27 (Row31 Col27) resistor r=10000.0
R_31_28 (Row31 Col28) resistor r=1000000.0
R_31_29 (Row31 Col29) resistor r=1000000.0
R_31_30 (Row31 Col30) resistor r=1000000.0
R_31_31 (Row31 Col31) resistor r=1000000.0
R_31_32 (Row31 Col32) resistor r=10000.0
R_32_1 (Row32 Col1) resistor r=1000000.0
R_32_2 (Row32 Col2) resistor r=10000.0
R_32_3 (Row32 Col3) resistor r=1000000.0
R_32_4 (Row32 Col4) resistor r=10000.0
R_32_5 (Row32 Col5) resistor r=1000000.0
R_32_6 (Row32 Col6) resistor r=10000.0
R_32_7 (Row32 Col7) resistor r=10000.0
R_32_8 (Row32 Col8) resistor r=10000.0
R_32_9 (Row32 Col9) resistor r=10000.0
R_32_10 (Row32 Col10) resistor r=10000.0
R_32_11 (Row32 Col11) resistor r=1000000.0
R_32_12 (Row32 Col12) resistor r=10000.0
R_32_13 (Row32 Col13) resistor r=1000000.0
R_32_14 (Row32 Col14) resistor r=10000.0
R_32_15 (Row32 Col15) resistor r=1000000.0
R_32_16 (Row32 Col16) resistor r=1000000.0
R_32_17 (Row32 Col17) resistor r=1000000.0
R_32_18 (Row32 Col18) resistor r=10000.0
R_32_19 (Row32 Col19) resistor r=10000.0
R_32_20 (Row32 Col20) resistor r=10000.0
R_32_21 (Row32 Col21) resistor r=1000000.0
R_32_22 (Row32 Col22) resistor r=1000000.0
R_32_23 (Row32 Col23) resistor r=1000000.0
R_32_24 (Row32 Col24) resistor r=10000.0
R_32_25 (Row32 Col25) resistor r=10000.0
R_32_26 (Row32 Col26) resistor r=1000000.0
R_32_27 (Row32 Col27) resistor r=1000000.0
R_32_28 (Row32 Col28) resistor r=10000.0
R_32_29 (Row32 Col29) resistor r=10000.0
R_32_30 (Row32 Col30) resistor r=10000.0
R_32_31 (Row32 Col31) resistor r=10000.0
R_32_32 (Row32 Col32) resistor r=1000000.0
Rf_1 Row1 Col1 resistor r=10000.0/(5.750986231409151-($time)*(5.750986231409151/5e-07))
Rf_2 Row2 Col2 resistor r=10000.0/(5.750986231409151-($time)*(5.750986231409151/5e-07))
Rf_3 Row3 Col3 resistor r=10000.0/(5.750986231409151-($time)*(5.750986231409151/5e-07))
Rf_4 Row4 Col4 resistor r=10000.0/(5.750986231409151-($time)*(5.750986231409151/5e-07))
Rf_5 Row5 Col5 resistor r=10000.0/(5.750986231409151-($time)*(5.750986231409151/5e-07))
Rf_6 Row6 Col6 resistor r=10000.0/(5.750986231409151-($time)*(5.750986231409151/5e-07))
Rf_7 Row7 Col7 resistor r=10000.0/(5.750986231409151-($time)*(5.750986231409151/5e-07))
Rf_8 Row8 Col8 resistor r=10000.0/(5.750986231409151-($time)*(5.750986231409151/5e-07))
Rf_9 Row9 Col9 resistor r=10000.0/(5.750986231409151-($time)*(5.750986231409151/5e-07))
Rf_10 Row10 Col10 resistor r=10000.0/(5.750986231409151-($time)*(5.750986231409151/5e-07))
Rf_11 Row11 Col11 resistor r=10000.0/(5.750986231409151-($time)*(5.750986231409151/5e-07))
Rf_12 Row12 Col12 resistor r=10000.0/(5.750986231409151-($time)*(5.750986231409151/5e-07))
Rf_13 Row13 Col13 resistor r=10000.0/(5.750986231409151-($time)*(5.750986231409151/5e-07))
Rf_14 Row14 Col14 resistor r=10000.0/(5.750986231409151-($time)*(5.750986231409151/5e-07))
Rf_15 Row15 Col15 resistor r=10000.0/(5.750986231409151-($time)*(5.750986231409151/5e-07))
Rf_16 Row16 Col16 resistor r=10000.0/(5.750986231409151-($time)*(5.750986231409151/5e-07))
Rf_17 Row17 Col17 resistor r=10000.0/(5.750986231409151-($time)*(5.750986231409151/5e-07))
Rf_18 Row18 Col18 resistor r=10000.0/(5.750986231409151-($time)*(5.750986231409151/5e-07))
Rf_19 Row19 Col19 resistor r=10000.0/(5.750986231409151-($time)*(5.750986231409151/5e-07))
Rf_20 Row20 Col20 resistor r=10000.0/(5.750986231409151-($time)*(5.750986231409151/5e-07))
Rf_21 Row21 Col21 resistor r=10000.0/(5.750986231409151-($time)*(5.750986231409151/5e-07))
Rf_22 Row22 Col22 resistor r=10000.0/(5.750986231409151-($time)*(5.750986231409151/5e-07))
Rf_23 Row23 Col23 resistor r=10000.0/(5.750986231409151-($time)*(5.750986231409151/5e-07))
Rf_24 Row24 Col24 resistor r=10000.0/(5.750986231409151-($time)*(5.750986231409151/5e-07))
Rf_25 Row25 Col25 resistor r=10000.0/(5.750986231409151-($time)*(5.750986231409151/5e-07))
Rf_26 Row26 Col26 resistor r=10000.0/(5.750986231409151-($time)*(5.750986231409151/5e-07))
Rf_27 Row27 Col27 resistor r=10000.0/(5.750986231409151-($time)*(5.750986231409151/5e-07))
Rf_28 Row28 Col28 resistor r=10000.0/(5.750986231409151-($time)*(5.750986231409151/5e-07))
Rf_29 Row29 Col29 resistor r=10000.0/(5.750986231409151-($time)*(5.750986231409151/5e-07))
Rf_30 Row30 Col30 resistor r=10000.0/(5.750986231409151-($time)*(5.750986231409151/5e-07))
Rf_31 Row31 Col31 resistor r=10000.0/(5.750986231409151-($time)*(5.750986231409151/5e-07))
Rf_32 Row32 Col32 resistor r=10000.0/(5.750986231409151-($time)*(5.750986231409151/5e-07))
OA_1 (0 Col1 Row1) opamp Voh=0.2 Vol=-0.2 Gain=1000 GBW=500M Rdc=30 Rac=10
OA_2 (0 Col2 Row2) opamp Voh=0.2 Vol=-0.2 Gain=1000 GBW=500M Rdc=30 Rac=10
OA_3 (0 Col3 Row3) opamp Voh=0.2 Vol=-0.2 Gain=1000 GBW=500M Rdc=30 Rac=10
OA_4 (0 Col4 Row4) opamp Voh=0.2 Vol=-0.2 Gain=1000 GBW=500M Rdc=30 Rac=10
OA_5 (0 Col5 Row5) opamp Voh=0.2 Vol=-0.2 Gain=1000 GBW=500M Rdc=30 Rac=10
OA_6 (0 Col6 Row6) opamp Voh=0.2 Vol=-0.2 Gain=1000 GBW=500M Rdc=30 Rac=10
OA_7 (0 Col7 Row7) opamp Voh=0.2 Vol=-0.2 Gain=1000 GBW=500M Rdc=30 Rac=10
OA_8 (0 Col8 Row8) opamp Voh=0.2 Vol=-0.2 Gain=1000 GBW=500M Rdc=30 Rac=10
OA_9 (0 Col9 Row9) opamp Voh=0.2 Vol=-0.2 Gain=1000 GBW=500M Rdc=30 Rac=10
OA_10 (0 Col10 Row10) opamp Voh=0.2 Vol=-0.2 Gain=1000 GBW=500M Rdc=30 Rac=10
OA_11 (0 Col11 Row11) opamp Voh=0.2 Vol=-0.2 Gain=1000 GBW=500M Rdc=30 Rac=10
OA_12 (0 Col12 Row12) opamp Voh=0.2 Vol=-0.2 Gain=1000 GBW=500M Rdc=30 Rac=10
OA_13 (0 Col13 Row13) opamp Voh=0.2 Vol=-0.2 Gain=1000 GBW=500M Rdc=30 Rac=10
OA_14 (0 Col14 Row14) opamp Voh=0.2 Vol=-0.2 Gain=1000 GBW=500M Rdc=30 Rac=10
OA_15 (0 Col15 Row15) opamp Voh=0.2 Vol=-0.2 Gain=1000 GBW=500M Rdc=30 Rac=10
OA_16 (0 Col16 Row16) opamp Voh=0.2 Vol=-0.2 Gain=1000 GBW=500M Rdc=30 Rac=10
OA_17 (0 Col17 Row17) opamp Voh=0.2 Vol=-0.2 Gain=1000 GBW=500M Rdc=30 Rac=10
OA_18 (0 Col18 Row18) opamp Voh=0.2 Vol=-0.2 Gain=1000 GBW=500M Rdc=30 Rac=10
OA_19 (0 Col19 Row19) opamp Voh=0.2 Vol=-0.2 Gain=1000 GBW=500M Rdc=30 Rac=10
OA_20 (0 Col20 Row20) opamp Voh=0.2 Vol=-0.2 Gain=1000 GBW=500M Rdc=30 Rac=10
OA_21 (0 Col21 Row21) opamp Voh=0.2 Vol=-0.2 Gain=1000 GBW=500M Rdc=30 Rac=10
OA_22 (0 Col22 Row22) opamp Voh=0.2 Vol=-0.2 Gain=1000 GBW=500M Rdc=30 Rac=10
OA_23 (0 Col23 Row23) opamp Voh=0.2 Vol=-0.2 Gain=1000 GBW=500M Rdc=30 Rac=10
OA_24 (0 Col24 Row24) opamp Voh=0.2 Vol=-0.2 Gain=1000 GBW=500M Rdc=30 Rac=10
OA_25 (0 Col25 Row25) opamp Voh=0.2 Vol=-0.2 Gain=1000 GBW=500M Rdc=30 Rac=10
OA_26 (0 Col26 Row26) opamp Voh=0.2 Vol=-0.2 Gain=1000 GBW=500M Rdc=30 Rac=10
OA_27 (0 Col27 Row27) opamp Voh=0.2 Vol=-0.2 Gain=1000 GBW=500M Rdc=30 Rac=10
OA_28 (0 Col28 Row28) opamp Voh=0.2 Vol=-0.2 Gain=1000 GBW=500M Rdc=30 Rac=10
OA_29 (0 Col29 Row29) opamp Voh=0.2 Vol=-0.2 Gain=1000 GBW=500M Rdc=30 Rac=10
OA_30 (0 Col30 Row30) opamp Voh=0.2 Vol=-0.2 Gain=1000 GBW=500M Rdc=30 Rac=10
OA_31 (0 Col31 Row31) opamp Voh=0.2 Vol=-0.2 Gain=1000 GBW=500M Rdc=30 Rac=10
OA_32 (0 Col32 Row32) opamp Voh=0.2 Vol=-0.2 Gain=1000 GBW=500M Rdc=30 Rac=10

tran tran stop=5e-07 errpreset=liberal \
  annotate=status maxiters=5 \
  noisefmax=1e10 mc_auto_noiseseed=yes noisescale=1
save Row1 Row2 Row3 Row4 Row5 Row6 Row7 Row8 Row9 Row10 Row11 Row12 Row13 Row14 Row15 Row16 Row17 Row18 Row19 Row20 Row21 Row22 Row23 Row24 Row25 Row26 Row27 Row28 Row29 Row30 Row31 Row32
